ADE simulation setup
Run mode: Single Run, Sweeps and Corners
Tests:
  AMP_CONFIG:gfet_bias:1: AMP_CONFIG/gfet_bias/schematic, simulator spectre
  AMP_CONFIG:gfet_bias:1:1 (off): AMP_CONFIG/gfet_bias/schematic, simulator spectre
Global variables:
  Nf = 3.9e16
  VDS = 1
  VGS = -1,-0.5,-0.625,-0.75,0,0.5
  L = 2u
  W = 20u
  RC = 0
