printf("libInit.il file is loaded\n")

load("./GPDK_1UM/mim_cap.cb")
load("./GPDK_1UM/graph_res.cb")
