// VerilogA for GPDK_1UM, ind_2n8, veriloga

`include "constants.vams"
`include "disciplines.vams"

module ind_2n8(MINUS, PLUS);
inout MINUS;
electrical MINUS;
inout PLUS;
electrical PLUS;
parameter real r = 1 ;
parameter real l = 2.8n ;

//parameter real model = ind_2n8 ;

analog begin
    V(PLUS,MINUS) <+ l*ddt(I(PLUS,MINUS)) + r*I(PLUS,MINUS);
end

endmodule
